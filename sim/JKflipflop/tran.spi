*TB_SUN_TR_SKY130NM/TB_NCM
*----------------------------------------------------------------
* Include
*----------------------------------------------------------------
#ifdef Lay
.include ../../../work/lpe/JKflipflop_lpe.spi
#else
.include ../../../work/xsch/JKflipflop.spice
#endif

*-----------------------------------------------------------------
* OPTIONS
*-----------------------------------------------------------------
.option TNOM=27 GMIN=1e-15 reltol=1e-3

*-----------------------------------------------------------------
* PARAMETERS
*-----------------------------------------------------------------
.param TRF = 10p
.param PERIOD_CLK = 20n
.param vdda = 1.8
.param AVDD = {vdda}

*-----------------------------------------------------------------
* FORCE
*-----------------------------------------------------------------
VSS   VSS   0     dc 0
VDD   VDD   VSS   dc 1.8
VJ    J     0     dc 1.8
VK    K     0     dc 0    pulse (0 {AVDD} 20n {TRF} {TRF} {PERIOD_CLK*5} {PERIOD_CLK*5})
VCLK  CLK   0     dc 0    pulse (0 {AVDD} 5n {TRF} {TRF} {PERIOD_CLK/2} {PERIOD_CLK})

*-----------------------------------------------------------------
* DUT
*-----------------------------------------------------------------
.include ../xdut.spi

*----------------------------------------------------------------
* PROBE
*----------------------------------------------------------------
.save all

*----------------------------------------------------------------
* NGSPICE control
*----------------------------------------------------------------
.control
set num_threads=8
set color0=white
set color1=black
unset askquit

tran 1n 100n
write
quit

.endc

.end
